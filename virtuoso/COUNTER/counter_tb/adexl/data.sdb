ADE simulation setup
Run mode: Single Run, Sweeps and Corners
Tests:
  COUNTER:counter_tb:1: COUNTER/counter_tb/config, simulator ams
