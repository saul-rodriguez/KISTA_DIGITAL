//Verilog-AMS HDL for "COUNTER", "counter_stimulus" "verilogams"

`include "constants.vams"
`include "disciplines.vams"

`timescale 1ns / 1ps

module counter_stimulus (clk, enable, reset  );

  output enable;
  output reset;
  output clk;

  reg clk, reset, enable;

  initial begin
//$dumpfile("dump.vcd");
//$dumpvars(0,counter1);
  clk = 0;
  reset = 0;
  enable = 0;
 #24 reset = 1;
 #20 reset = 0;
 #20 enable = 1;
 #500 $finish;
 end

 initial begin
   $sdf_annotate("/home/saul/projects/KISTA_DIGITAL/innovus/output/TOP_TM_typ_RC_1_8V_25C.sdf",I0,,"sdf.log","MAXIMUM");
 end

  always begin
#10 clk = ~clk;
  end

endmodule
